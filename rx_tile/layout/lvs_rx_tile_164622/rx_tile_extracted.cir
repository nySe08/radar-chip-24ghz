* Extracted by KLayout with SG13G2 LVS runset on : 12/10/2026 16:46

.SUBCKT rx_tile GND IFN IFP IREF LA LA|VCC LB LB$1 LON LOP RFIN
Q$1 IREF \$28 GND GND npn13G2 we=70n le=900n Nx=1 m=1
Q$2 LA|VCC IREF \$49 GND npn13G2 we=70n le=900n Nx=1 m=1
Q$3 \$82 LA GND GND npn13G2 we=70n le=900n Nx=8 m=1
Q$4 LB$1 \$77 \$82 GND npn13G2 we=70n le=900n Nx=8 m=1
Q$5 \$169 \$170 \$168 GND npn13G2 we=70n le=900n Nx=4 m=1
Q$6 \$130 \$130 \$145 GND npn13G2 we=70n le=900n Nx=1 m=1
Q$7 IFP \$186 \$169 GND npn13G2 we=70n le=900n Nx=2 m=1
Q$8 IFN \$187 \$169 GND npn13G2 we=70n le=900n Nx=2 m=1
Q$9 \$207 \$232 \$221 GND npn13G2 we=70n le=900n Nx=2 m=1
Q$10 \$208 \$233 \$221 GND npn13G2 we=70n le=900n Nx=2 m=1
R$11 GND \$145 GND rsil w=1u l=38.2u ps=0u b=0 m=1
R$12 \$130 \$170 GND rsil w=1u l=7.55u ps=0u b=0 m=1
R$13 GND \$168 GND rsil w=1u l=9.55u ps=0u b=0 m=1
R$14 \$49 LA GND rppd w=1u l=19.08u ps=0u b=0 m=1
R$15 \$77 LA|VCC GND rppd w=1u l=22.95u ps=0u b=0 m=1
R$16 LA|VCC LB$1 GND rppd w=2u l=5.37u ps=0u b=0 m=1
R$17 \$139 LA|VCC GND rppd w=1u l=22.95u ps=0u b=0 m=1
R$18 \$130 LA|VCC GND rppd w=1u l=4.37u ps=0u b=0 m=1
R$19 \$139 \$186 GND rppd w=1u l=7.47u ps=0u b=0 m=1
R$20 \$139 \$187 GND rppd w=1u l=7.47u ps=0u b=0 m=1
R$21 IFP LA|VCC GND rppd w=2u l=2.05u ps=0u b=0 m=1
R$22 IFN LA|VCC GND rppd w=2u l=2.05u ps=0u b=0 m=1
R$23 GND \$221 GND rppd w=2u l=0.79u ps=0u b=0 m=1
R$24 LA|VCC \$207 GND rppd w=2u l=1.28u ps=0u b=0 m=1
R$25 LA|VCC \$208 GND rppd w=2u l=1.28u ps=0u b=0 m=1
R$26 GND \$231 GND rppd w=1u l=20.63u ps=0u b=0 m=1
R$27 LA|VCC \$231 GND rppd w=1u l=17.53u ps=0u b=0 m=1
R$28 \$232 \$231 GND rppd w=1u l=19.08u ps=0u b=0 m=1
R$29 \$233 \$231 GND rppd w=1u l=19.08u ps=0u b=0 m=1
R$30 \$28 \$49 GND rhigh w=1u l=28.12u ps=0u b=0 m=1
R$31 GND \$49 GND rhigh w=1u l=12.03u ps=0u b=0 m=1
R$32 \$77 GND GND rhigh w=1u l=13.3u ps=0u b=0 m=1
R$33 GND \$139 GND rhigh w=1u l=13.3u ps=0u b=0 m=1
C$34 LA|VCC IFP cap_cmim w=34.3u l=34.3u A=1176.49p P=137.2u m=1
C$35 LA|VCC IFN cap_cmim w=34.3u l=34.3u A=1176.49p P=137.2u m=1
C$36 \$231 GND GND rfcmim w=33u l=33u A=1089p P=132u m=1 wfeed=3u
C$37 \$208 \$187 GND rfcmim w=12u l=12u A=144p P=48u m=1 wfeed=3u
C$38 LOP \$232 GND rfcmim w=25u l=25u A=625p P=100u m=1 wfeed=3u
C$39 LA|VCC GND GND rfcmim w=33u l=33u A=1089p P=132u m=2 wfeed=3u
C$40 LB RFIN GND rfcmim w=33u l=33u A=1089p P=132u m=1 wfeed=3u
C$42 \$49 GND GND rfcmim w=33u l=33u A=1089p P=132u m=1 wfeed=3u
C$43 \$77 GND GND rfcmim w=33u l=33u A=1089p P=132u m=2 wfeed=3u
C$44 \$207 \$186 GND rfcmim w=12u l=12u A=144p P=48u m=1 wfeed=3u
C$46 LON \$233 GND rfcmim w=25u l=25u A=625p P=100u m=1 wfeed=3u
C$47 \$165 LB$1 GND rfcmim w=7u l=7u A=49p P=28u m=1 wfeed=3u
C$48 \$130 GND GND rfcmim w=33u l=33u A=1089p P=132u m=1 wfeed=3u
C$49 \$165 \$170 GND rfcmim w=33u l=33u A=1089p P=132u m=1 wfeed=3u
C$50 \$139 GND GND rfcmim w=33u l=33u A=1089p P=132u m=1 wfeed=3u
L$51 LB LA GND inductor w=7u s=2.097u d=68.686u nr_r=2
L$52 LA|VCC LB$1 GND inductor w=5u s=2.097u d=55.856u nr_r=2
R$53 GND GND ptap1 A=20p P=40u
.ENDS rx_tile
