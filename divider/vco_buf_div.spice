* ============================================================
* 24 GHz VCO + LO buffer + divider /4  (IHP SG13G2)
*  LO buffer: emitter followers -> AC-coupled, re-biased bases ->
*  three differential drivers with tuned loads (LDx || RDx):
*    driver 1 -> mixer LO, driver 2 -> PA, driver 3 -> divider
*  PA and divider inputs are load models until those blocks exist.
* Run via run_lo_chain.py (it uses a robust start: DC solved without
* the varactor, then the transient starts from that point with UIC).
* ============================================================
.lib cornerHBT.lib hbt_typ
.lib cornerMOShv.lib mos_tt
.param temp=27
.param LH=330p QL=15 W0=1.5158e11      $ half-inductor (diff L = 660 pH), Q, 2*pi*24.125G
.param NXQ=4 ITAIL=3m VBB=1.5 CCB=200f RBB=2k    $ core transistors, tail current, base bias
.param NXV=10 CCV=250f VGB=1.25 RGB=10k VTUNE=1.25  $ varactor size, coupling cap, gate bias, tuning V
.param CLOAD=10f VCC=2.5 SELFT=1
* tank: center-tapped inductor (two halves, each with loss)
L1 vcc t1 {LH}
R1 t1 outp {W0*LH/QL}
L2 vcc t2 {LH}
R2 t2 outn {W0*LH/QL}
* varactor, AC-coupled, gates biased at VGB, well = Vtune
Ccv1 outp g1 {CCV}
Ccv2 outn g2 {CCV}
Rg1 vgb g1 {RGB}
Rg2 vgb g2 {RGB}
Vgb vgb 0 {VGB}
XV1 g1 vt g2 0 sg13_hv_svaricap l=0.3u w=9.74u Nx={NXV}
Vt vt 0 {VTUNE}
* cross-coupled pair with AC-coupled bases
XQ6 outp b6 tail 0 npn13G2 Nx={NXQ} selft={SELFT}
XQ7 outn b7 tail 0 npn13G2 Nx={NXQ} selft={SELFT}
Cb6 outn b6 {CCB}
Cb7 outp b7 {CCB}
Rb6 vbb b6 {RBB}
Rb7 vbb b7 {RBB}
Vbb vbb 0 {VBB}
It tail 0 {ITAIL}

* ================= LO BUFFER =================
.param NXEF=2 IEF=1.5m
.param NXD=2 ID1=2m ID2=2m ID3=1.5m
.param LD1=1.3n RD1=400 LD2=1.1n RD2=400 LD3=1.5n RD3=400
.param CC=500f
* --- load models (replaced by the real blocks later)
.param CMIX=25f RMIX=2k CPA=40f RPA=1k CDIV=10f RDIV=2k
* stage 1: emitter followers (high input impedance, level shift)
XQe1 vcc outp ef1 0 npn13G2 Nx={NXEF} selft={SELFT}
XQe2 vcc outn ef2 0 npn13G2 Nx={NXEF} selft={SELFT}
Ie1 ef1 0 {IEF}
Ie2 ef2 0 {IEF}
* AC coupling + re-bias of the driver bases (keeps the drivers out of saturation)
.param CDB=1p RDB=2k VBD=1.35
Cdb1 ef1 b1 {CDB}
Cdb2 ef2 b2 {CDB}
Rdb1 vbd b1 {RDB}
Rdb2 vbd b2 {RDB}
Vbd vbd 0 {VBD}
* stage 2: three parallel differential drivers with tuned loads
* driver 1 -> mixer LO
XQ11 d1p b2 dt1 0 npn13G2 Nx={NXD} selft={SELFT}
XQ12 d1n b1 dt1 0 npn13G2 Nx={NXD} selft={SELFT}
It1 dt1 0 {ID1}
L11 vcc d1p {LD1}
L12 vcc d1n {LD1}
R11 vcc d1p {RD1}
R12 vcc d1n {RD1}
* driver 2 -> PA
XQ21 d2p b2 dt2 0 npn13G2 Nx={NXD} selft={SELFT}
XQ22 d2n b1 dt2 0 npn13G2 Nx={NXD} selft={SELFT}
It2 dt2 0 {ID2}
L21 vcc d2p {LD2}
L22 vcc d2n {LD2}
R21 vcc d2p {RD2}
R22 vcc d2n {RD2}
* driver 3 -> divider
XQ31 d3p b2 dt3 0 npn13G2 Nx={NXD} selft={SELFT}
XQ32 d3n b1 dt3 0 npn13G2 Nx={NXD} selft={SELFT}
It3 dt3 0 {ID3}
L31 vcc d3p {LD3}
L32 vcc d3n {LD3}
R31 vcc d3p {RD3}
R32 vcc d3n {RD3}
* AC-coupled load models
Cm1 d1p m1 {CC}
Cm2 d1n m2 {CC}
Cmx1 m1 0 {CMIX}
Cmx2 m2 0 {CMIX}
Rmx1 m1 vlo {RMIX}
Rmx2 m2 vlo {RMIX}
Vlo vlo 0 1.9
Cp1 d2p p1 {CC}
Cp2 d2n p2 {CC}
Cpa1 p1 0 {CPA}
Cpa2 p2 0 {CPA}
Rpa1 p1 vpa {RPA}
Rpa2 p2 vpa {RPA}
Vpa vpa 0 1.0
Cd1 d3p q1 {CC}
Cd2 d3n q2 {CC}
Rdv1 q1 vdv {RDIV}
Rdv2 q2 vdv {RDIV}
Vdv vdv 0 {VCK}

* ================= DIVIDER /4 (clocked by LO-buffer driver 3) =================
.param IT1=1.5m RL1=266 IT2=1m RL2=400 NXL=1 VCK=1.2 CCD=500f RBD=5k IOUT=8m NXO=4 ROUT=50 VBO=1.6
.subckt cml_latch d db ck ckb q qb vcc params: IT=2.5m RL=160 NX=1
RLp vcc q  {RL}
RLn vcc qb {RL}
* data pair (transparent when ck high): D high -> current through Qd1 -> qb low, q high
Xd1 qb d  ed 0 npn13G2 Nx={NX}
Xd2 q  db ed 0 npn13G2 Nx={NX}
* hold pair (cross-coupled, active when ck low)
Xh1 qb q  eh 0 npn13G2 Nx={NX}
Xh2 q  qb eh 0 npn13G2 Nx={NX}
* clock pair
Xc1 ed ck  et 0 npn13G2 Nx={NX}
Xc2 eh ckb et 0 npn13G2 Nx={NX}
It et 0 {IT}
.ends
Xm1 s1qb s1q q1 q2 m1q m1qb vcc cml_latch IT={IT1} RL={RL1} NX={NXL}
Xs1 m1q m1qb q2 q1 s1q s1qb vcc cml_latch IT={IT1} RL={RL1} NX={NXL}
Cc1 s1q  c2p {CCD}
Cc2 s1qb c2n {CCD}
Rb1 vckd c2p {RBD}
Rb2 vckd c2n {RBD}
Vckd vckd 0 {VCK}
Xm2 s2qb s2q c2p c2n m2q m2qb vcc cml_latch IT={IT2} RL={RL2} NX={NXL}
Xs2 m2q m2qb c2n c2p s2q s2qb vcc cml_latch IT={IT2} RL={RL2} NX={NXL}
Co1 s2q  o1 {CCD}
Co2 s2qb o2 {CCD}
Rbo1 vbo o1 {RBD}
Rbo2 vbo o2 {RBD}
Vbo vbo 0 {VBO}
Xo1 padn o1 eo 0 npn13G2 Nx={NXO}
Xo2 padp o2 eo 0 npn13G2 Nx={NXO}
Io eo 0 {IOUT}
Rt1 vcc padp {ROUT}
Rt2 vcc padn {ROUT}
Cx1 padp pllp 10p
Cx2 padn plln 10p
Rx1 pllp 0 50
Rx2 plln 0 50
Ik1 s1q 0 pulse(0 0.5m 0 5p 5p 20p 1)
Ik2 s2q 0 pulse(0 0.5m 0 5p 5p 20p 1)
* start-up kick
Ik outp 0 pulse(0 1m 0 5p 5p 10p 1)
Vcc vcc 0 {VCC}
.control
set noaskquit
tran 0.5p 6n
let vd = v(outp)-v(outn)
wrdata vco_tran.txt vd v(m1) v(m2) v(p1) v(p2) v(q1) v(q2) v(pllp)
.endc
.end
