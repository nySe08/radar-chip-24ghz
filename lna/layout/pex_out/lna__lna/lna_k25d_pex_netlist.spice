*********************************************************
*** NGSPICE file created by KLayout-PEX 0.4.4
*** -----------------------------------------------------
***     Extraction Engine: KPEX/2.5D
***     Technology: ihp_sg13g2
***     Date: 2026-10-16 04:44:46
*********************************************************

.SUBCKT lna GND IREF RFIN RFOUT VCC
