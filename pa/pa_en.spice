* ============================================================
* 24 GHz PA with ENABLE (TDM-MIMO TX switching) - IHP SG13G2
* Current steering: when EN_B is high (1.2 V),
*   M1 steers Iref to ground (Qf base low -> bias follower off)
*   M2 pulls the bias node vbn to ground (Q1 hard off)
* Iref keeps flowing, so turn-on does not wait for the reference to settle.
* Test: PA off 0-20 ns, on 20-120 ns, off 120-200 ns.
* ============================================================
.lib cornerHBT.lib hbt_typ
.lib cornerMOSlv.lib mos_tt
.param temp=27
.param RE1=5 IREF=0.777m RB=1k RREF=8k VCAS=1.6 CBYP=5p LC=543p COUT=71f QL=15 W0=1.5158e11
.param AIN=0.35 RSRC=200 FIN=24.125e9 VCC=2.5
.param W1=10u W2=8u VLOG=1.2
Vs src 0 dc 0 sin(0 {AIN} {FIN})
Rsrc src a {RSRC}
Cin a b1 1p
* bias mirror
Iref vcc cr {IREF}
XQr  cr br er 0 npn13G2 Nx=1
Rer  er 0 {8*RE1}
XQf  vcc cr vbn 0 npn13G2 Nx=1
Ief  vbn 0 50u
Rref vbn br {RREF}
Rb   vbn b1 {RB}
Cbn  vbn 0 {CBYP}
* ---- enable switches (1.2 V NMOS), gate = EN_B (high = PA off)
XM1 cr  enb 0 0 sg13_lv_nmos w={W1} l=0.13u ng=1
XM2 vbn enb 0 0 sg13_lv_nmos w={W2} l=0.13u ng=1
Venb enb 0 pwl(0 {VLOG} 20n {VLOG} 20.1n 0 120n 0 120.1n {VLOG})
* PA core
XQ1  c1 b1 e1 0 npn13G2 Nx=8
Re1  e1 0 {RE1}
XQ2  out vcas c1 0 npn13G2v Nx=8
Vcas vcas 0 {VCAS}
Ccas vcas 0 {CBYP}
Lc   vcc lx {LC}
RLc  lx out {W0*LC/QL}
Cout out ant {COUT}
Rant ant 0 50
Vcc  vcc 0 {VCC}
.control
set noaskquit
tran 0.5p 200n 0 0.5p
wrdata pa_en.txt v(ant) i(vcc) v(vbn) v(enb)
.endc
.end
