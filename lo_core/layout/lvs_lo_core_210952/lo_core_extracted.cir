* Extracted by KLayout with SG13G2 LVS runset on : 12/10/2026 21:09

.SUBCKT lo_core G1 G2 GND LA LA$1 LA$2 LB LB$1 LB$2 LC|VCC PLLN PLLP RXLON
+ RXLOP TXLON TXLOP VTUNE|W
Q$1 \$18 \$131 \$10 GND npn13G2 we=70n le=900n Nx=2 m=1
Q$2 \$19 \$131 \$11 GND npn13G2 we=70n le=900n Nx=3 m=1
Q$3 \$131 \$131 \$12 GND npn13G2 we=70n le=900n Nx=1 m=1
Q$4 \$44 \$7 \$18 GND npn13G2 we=70n le=900n Nx=1 m=1
Q$5 \$45 \$441 \$44 GND npn13G2 we=70n le=900n Nx=1 m=1
Q$6 \$45 \$46 \$74 GND npn13G2 we=70n le=900n Nx=1 m=1
Q$7 \$46 \$45 \$74 GND npn13G2 we=70n le=900n Nx=1 m=1
Q$8 \$74 \$3 \$18 GND npn13G2 we=70n le=900n Nx=1 m=1
Q$9 \$47 \$8 \$19 GND npn13G2 we=70n le=900n Nx=1 m=1
Q$10 \$49 \$42 \$47 GND npn13G2 we=70n le=900n Nx=1 m=1
Q$11 \$48 \$49 \$75 GND npn13G2 we=70n le=900n Nx=1 m=1
Q$12 \$49 \$48 \$75 GND npn13G2 we=70n le=900n Nx=1 m=1
Q$13 \$46 \$41 \$44 GND npn13G2 we=70n le=900n Nx=1 m=1
Q$14 \$48 \$257 \$47 GND npn13G2 we=70n le=900n Nx=1 m=1
Q$15 \$75 \$4 \$19 GND npn13G2 we=70n le=900n Nx=1 m=1
Q$16 \$156 \$3 \$135 GND npn13G2 we=70n le=900n Nx=1 m=1
Q$17 \$441 \$46 \$156 GND npn13G2 we=70n le=900n Nx=1 m=1
Q$18 \$41 \$45 \$156 GND npn13G2 we=70n le=900n Nx=1 m=1
Q$19 \$135 \$131 \$134 GND npn13G2 we=70n le=900n Nx=2 m=1
Q$20 \$441 \$41 \$183 GND npn13G2 we=70n le=900n Nx=1 m=1
Q$21 \$183 \$7 \$135 GND npn13G2 we=70n le=900n Nx=1 m=1
Q$22 \$157 \$4 \$136 GND npn13G2 we=70n le=900n Nx=1 m=1
Q$23 \$257 \$49 \$157 GND npn13G2 we=70n le=900n Nx=1 m=1
Q$24 \$42 \$48 \$157 GND npn13G2 we=70n le=900n Nx=1 m=1
Q$25 \$136 \$131 \$140 GND npn13G2 we=70n le=900n Nx=3 m=1
Q$26 \$257 \$42 \$184 GND npn13G2 we=70n le=900n Nx=1 m=1
Q$27 \$42 \$257 \$184 GND npn13G2 we=70n le=900n Nx=1 m=1
Q$28 \$184 \$8 \$136 GND npn13G2 we=70n le=900n Nx=1 m=1
Q$29 \$41 \$441 \$183 GND npn13G2 we=70n le=900n Nx=1 m=1
Q$30 \$407 \$131 \$413 GND npn13G2 we=70n le=900n Nx=10 m=1
Q$31 \$407 \$131 \$414 GND npn13G2 we=70n le=900n Nx=10 m=1
Q$32 \$305 \$347 \$338 GND npn13G2 we=70n le=900n Nx=2 m=1
Q$33 \$306 \$348 \$338 GND npn13G2 we=70n le=900n Nx=2 m=1
Q$34 LA \$273 \$270 GND npn13G2 we=70n le=900n Nx=2 m=1
Q$35 LC|VCC LA$2 \$330 GND npn13G2 we=70n le=900n Nx=2 m=1
Q$36 LC|VCC LB$2 \$331 GND npn13G2 we=70n le=900n Nx=2 m=1
Q$37 LB \$274 \$270 GND npn13G2 we=70n le=900n Nx=2 m=1
Q$38 PLLN \$380 \$407 GND npn13G2 we=70n le=900n Nx=4 m=1
Q$39 PLLP \$431 \$407 GND npn13G2 we=70n le=900n Nx=4 m=1
Q$40 LA$1 \$459 \$430 GND npn13G2 we=70n le=900n Nx=2 m=1
Q$41 LB$1 \$460 \$430 GND npn13G2 we=70n le=900n Nx=2 m=1
Q$42 LA$2 \$514 \$537 GND npn13G2 we=70n le=900n Nx=4 m=1
Q$43 LB$2 \$515 \$537 GND npn13G2 we=70n le=900n Nx=4 m=1
R$44 \$6 LC|VCC GND rppd w=1u l=15.21u ps=0u b=0 m=1
R$45 GND \$6 GND rppd w=1u l=22.95u ps=0u b=0 m=1
R$46 \$8 \$6 GND rppd w=1u l=7.47u ps=0u b=0 m=1
R$47 \$4 \$6 GND rppd w=1u l=7.47u ps=0u b=0 m=1
R$48 GND \$10 GND rppd w=4u l=2.05u ps=0u b=0 m=1
R$49 GND \$11 GND rppd w=4u l=1.28u ps=0u b=0 m=1
R$50 GND \$12 GND rppd w=2u l=2.05u ps=0u b=0 m=1
R$51 \$45 LC|VCC GND rppd w=2u l=2.83u ps=0u b=0 m=1
R$52 \$46 LC|VCC GND rppd w=2u l=2.83u ps=0u b=0 m=1
R$53 \$48 LC|VCC GND rppd w=2u l=1.79u ps=0u b=0 m=1
R$54 \$49 LC|VCC GND rppd w=2u l=1.79u ps=0u b=0 m=1
R$55 \$131 LC|VCC GND rppd w=1u l=11.34u ps=0u b=0 m=1
R$56 GND \$134 GND rppd w=4u l=2.05u ps=0u b=0 m=1
R$57 GND \$140 GND rppd w=4u l=1.28u ps=0u b=0 m=1
R$58 \$441 LC|VCC GND rppd w=2u l=2.83u ps=0u b=0 m=1
R$59 \$41 LC|VCC GND rppd w=2u l=2.83u ps=0u b=0 m=1
R$60 \$257 LC|VCC GND rppd w=2u l=1.79u ps=0u b=0 m=1
R$61 \$42 LC|VCC GND rppd w=2u l=1.79u ps=0u b=0 m=1
R$62 \$7 \$6 GND rppd w=1u l=19.08u ps=0u b=0 m=1
R$63 \$3 \$6 GND rppd w=1u l=19.08u ps=0u b=0 m=1
R$64 LC|VCC \$241 GND rppd w=1u l=17.53u ps=0u b=0 m=1
R$65 GND \$241 GND rppd w=1u l=20.63u ps=0u b=0 m=1
R$66 \$241 \$273 GND rppd w=1u l=19.08u ps=0u b=0 m=1
R$67 GND \$270 GND rppd w=2u l=0.94u ps=0u b=0 m=1
R$68 \$241 \$274 GND rppd w=1u l=19.08u ps=0u b=0 m=1
R$69 LC|VCC LA GND rppd w=2u l=2.83u ps=0u b=0 m=1
R$70 LC|VCC LB GND rppd w=2u l=2.83u ps=0u b=0 m=1
R$71 LC|VCC \$298 GND rppd w=1u l=17.53u ps=0u b=0 m=1
R$72 GND \$298 GND rppd w=1u l=20.63u ps=0u b=0 m=1
R$73 \$298 \$347 GND rppd w=1u l=19.08u ps=0u b=0 m=1
R$74 \$298 \$348 GND rppd w=1u l=19.08u ps=0u b=0 m=1
R$75 GND \$338 GND rppd w=2u l=1.86u ps=0u b=0 m=1
R$76 LC|VCC \$305 GND rppd w=2u l=2.05u ps=0u b=0 m=1
R$77 LC|VCC \$306 GND rppd w=2u l=2.05u ps=0u b=0 m=1
R$78 GND \$330 GND rppd w=2u l=8.24u ps=0u b=0 m=1
R$79 GND \$331 GND rppd w=2u l=8.24u ps=0u b=0 m=1
R$80 LC|VCC \$367 GND rppd w=1u l=17.53u ps=0u b=0 m=1
R$81 GND \$367 GND rppd w=1u l=20.63u ps=0u b=0 m=1
R$82 GND \$413 GND rppd w=8u l=0.66u ps=0u b=0 m=1
R$83 GND \$414 GND rppd w=8u l=0.66u ps=0u b=0 m=1
R$84 \$367 \$459 GND rppd w=1u l=19.08u ps=0u b=0 m=1
R$85 \$367 \$460 GND rppd w=1u l=19.08u ps=0u b=0 m=1
R$86 GND \$430 GND rppd w=2u l=1.86u ps=0u b=0 m=1
R$87 PLLN LC|VCC GND rppd w=10u l=1.66u ps=0u b=0 m=1
R$88 PLLP LC|VCC GND rppd w=10u l=1.66u ps=0u b=0 m=1
R$89 LC|VCC LA$1 GND rppd w=2u l=2.83u ps=0u b=0 m=1
R$90 LC|VCC LB$1 GND rppd w=2u l=2.83u ps=0u b=0 m=1
R$91 LC|VCC \$503 GND rppd w=1u l=15.21u ps=0u b=0 m=1
R$92 GND \$503 GND rppd w=1u l=22.95u ps=0u b=0 m=1
R$93 \$506 LC|VCC GND rppd w=1u l=17.14u ps=0u b=0 m=1
R$94 \$380 \$506 GND rppd w=1u l=19.08u ps=0u b=0 m=1
R$95 \$431 \$506 GND rppd w=1u l=19.08u ps=0u b=0 m=1
R$96 GND \$537 GND rppd w=2u l=1.41u ps=0u b=0 m=1
R$97 \$503 \$514 GND rppd w=1u l=7.47u ps=0u b=0 m=1
R$98 \$503 \$515 GND rppd w=1u l=7.47u ps=0u b=0 m=1
R$99 GND RXLOP GND rhigh w=1u l=14u ps=0u b=0 m=1
R$100 GND RXLON GND rhigh w=1u l=14u ps=0u b=0 m=1
R$101 GND TXLOP GND rhigh w=1u l=14u ps=0u b=0 m=1
R$102 GND TXLON GND rhigh w=1u l=14u ps=0u b=0 m=1
R$103 \$502 G1 GND rhigh w=1u l=7u ps=0u b=0 m=1
R$104 \$502 G2 GND rhigh w=1u l=7u ps=0u b=0 m=1
R$105 \$502 LC|VCC GND rhigh w=1u l=13.3u ps=0u b=0 m=1
R$106 \$502 GND GND rhigh w=1u l=13.3u ps=0u b=0 m=1
R$107 GND \$506 GND rhigh w=1u l=5.53u ps=0u b=0 m=1
C$108 \$6 GND GND rfcmim w=33u l=33u A=1089p P=132u m=1 wfeed=3u
C$109 \$131 GND GND rfcmim w=25u l=25u A=625p P=100u m=1 wfeed=3u
C$110 \$241 GND GND rfcmim w=33u l=33u A=1089p P=132u m=1 wfeed=3u
C$111 LA RXLOP GND rfcmim w=12u l=12u A=144p P=48u m=1 wfeed=3u
C$112 LB RXLON GND rfcmim w=12u l=12u A=144p P=48u m=1 wfeed=3u
C$113 \$42 \$7 GND rfcmim w=18.2u l=18.2u A=331.24p P=72.8u m=1 wfeed=3u
C$114 \$257 \$3 GND rfcmim w=18.2u l=18.2u A=331.24p P=72.8u m=1 wfeed=3u
C$115 \$298 GND GND rfcmim w=33u l=33u A=1089p P=132u m=1 wfeed=3u
C$116 \$305 \$8 GND rfcmim w=12u l=12u A=144p P=48u m=1 wfeed=3u
C$117 \$306 \$4 GND rfcmim w=12u l=12u A=144p P=48u m=1 wfeed=3u
C$118 \$330 \$273 GND rfcmim w=25u l=25u A=625p P=100u m=1 wfeed=3u
C$119 \$331 \$274 GND rfcmim w=25u l=25u A=625p P=100u m=1 wfeed=3u
C$120 \$367 GND GND rfcmim w=33u l=33u A=1089p P=132u m=1 wfeed=3u
C$121 LA$1 TXLOP GND rfcmim w=12u l=12u A=144p P=48u m=1 wfeed=3u
C$122 LB$1 TXLON GND rfcmim w=12u l=12u A=144p P=48u m=1 wfeed=3u
C$123 \$41 \$380 GND rfcmim w=18.2u l=18.2u A=331.24p P=72.8u m=1 wfeed=3u
C$124 \$330 \$347 GND rfcmim w=25u l=25u A=625p P=100u m=1 wfeed=3u
C$125 \$331 \$348 GND rfcmim w=25u l=25u A=625p P=100u m=1 wfeed=3u
C$126 \$441 \$431 GND rfcmim w=18.2u l=18.2u A=331.24p P=72.8u m=1 wfeed=3u
C$127 \$502 GND GND rfcmim w=33u l=33u A=1089p P=132u m=1 wfeed=3u
C$128 LA$2 G1 GND rfcmim w=11.3u l=11.3u A=127.69p P=45.2u m=1 wfeed=3u
C$129 LB$2 G2 GND rfcmim w=11.3u l=11.3u A=127.69p P=45.2u m=1 wfeed=3u
C$130 \$503 GND GND rfcmim w=33u l=33u A=1089p P=132u m=1 wfeed=3u
C$131 \$506 GND GND rfcmim w=33u l=33u A=1089p P=132u m=1 wfeed=3u
C$132 LB$2 \$514 GND rfcmim w=11.5u l=11.5u A=132.25p P=46u m=1 wfeed=3u
C$133 LA$2 \$515 GND rfcmim w=11.5u l=11.5u A=132.25p P=46u m=1 wfeed=3u
C$134 \$330 \$459 GND rfcmim w=25u l=25u A=625p P=100u m=1 wfeed=3u
C$135 \$331 \$460 GND rfcmim w=25u l=25u A=625p P=100u m=1 wfeed=3u
C$136 G1 VTUNE|W G2 GND sg13_hv_svaricap w=9.74u l=0.3u Nx=10
L$137 LB LC|VCC LA GND inductor3 w=4u s=2.097u d=65.386u nr_r=2
L$138 LA$2 LC|VCC LB$2 GND inductor3 w=6u s=2.097u d=70.906u nr_r=2
L$139 LA$1 LC|VCC LB$1 GND inductor3 w=4u s=2.097u d=83.496u nr_r=2
.ENDS lo_core
