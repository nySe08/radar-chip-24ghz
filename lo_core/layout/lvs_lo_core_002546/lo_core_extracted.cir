* Extracted by KLayout with SG13G2 LVS runset on : 13/10/2026 00:25

.SUBCKT lo_core G1 G2 GND LA LA$1 LA$2 LB LB$1 LB$2 LC|VCC PLLN PLLP RXLON
+ RXLOP TXLON TXLOP VTUNE|W
Q$1 \$18 \$132 \$10 GND npn13G2 we=70n le=900n Nx=2 m=1
Q$2 \$19 \$132 \$11 GND npn13G2 we=70n le=900n Nx=3 m=1
Q$3 \$132 \$132 \$12 GND npn13G2 we=70n le=900n Nx=1 m=1
Q$4 \$46 \$47 \$75 GND npn13G2 we=70n le=900n Nx=1 m=1
Q$5 \$47 \$46 \$75 GND npn13G2 we=70n le=900n Nx=1 m=1
Q$6 \$75 \$3 \$18 GND npn13G2 we=70n le=900n Nx=1 m=1
Q$7 \$48 \$8 \$19 GND npn13G2 we=70n le=900n Nx=1 m=1
Q$8 \$50 \$42 \$48 GND npn13G2 we=70n le=900n Nx=1 m=1
Q$9 \$49 \$50 \$76 GND npn13G2 we=70n le=900n Nx=1 m=1
Q$10 \$50 \$49 \$76 GND npn13G2 we=70n le=900n Nx=1 m=1
Q$11 \$76 \$4 \$19 GND npn13G2 we=70n le=900n Nx=1 m=1
Q$12 \$45 \$7 \$18 GND npn13G2 we=70n le=900n Nx=1 m=1
Q$13 \$46 \$44 \$45 GND npn13G2 we=70n le=900n Nx=1 m=1
Q$14 \$47 \$41 \$45 GND npn13G2 we=70n le=900n Nx=1 m=1
Q$15 \$49 \$258 \$48 GND npn13G2 we=70n le=900n Nx=1 m=1
Q$16 \$157 \$3 \$136 GND npn13G2 we=70n le=900n Nx=1 m=1
Q$17 \$44 \$47 \$157 GND npn13G2 we=70n le=900n Nx=1 m=1
Q$18 \$41 \$46 \$157 GND npn13G2 we=70n le=900n Nx=1 m=1
Q$19 \$136 \$132 \$135 GND npn13G2 we=70n le=900n Nx=2 m=1
Q$20 \$44 \$41 \$184 GND npn13G2 we=70n le=900n Nx=1 m=1
Q$21 \$41 \$44 \$184 GND npn13G2 we=70n le=900n Nx=1 m=1
Q$22 \$158 \$4 \$137 GND npn13G2 we=70n le=900n Nx=1 m=1
Q$23 \$258 \$50 \$158 GND npn13G2 we=70n le=900n Nx=1 m=1
Q$24 \$42 \$49 \$158 GND npn13G2 we=70n le=900n Nx=1 m=1
Q$25 \$137 \$132 \$143 GND npn13G2 we=70n le=900n Nx=3 m=1
Q$26 \$185 \$8 \$137 GND npn13G2 we=70n le=900n Nx=1 m=1
Q$27 \$184 \$7 \$136 GND npn13G2 we=70n le=900n Nx=1 m=1
Q$28 \$258 \$42 \$185 GND npn13G2 we=70n le=900n Nx=1 m=1
Q$29 \$42 \$258 \$185 GND npn13G2 we=70n le=900n Nx=1 m=1
Q$30 \$396 \$132 \$402 GND npn13G2 we=70n le=900n Nx=10 m=1
Q$31 \$396 \$132 \$403 GND npn13G2 we=70n le=900n Nx=10 m=1
Q$32 \$306 \$348 \$339 GND npn13G2 we=70n le=900n Nx=2 m=1
Q$33 \$307 \$349 \$339 GND npn13G2 we=70n le=900n Nx=2 m=1
Q$34 LA \$274 \$268 GND npn13G2 we=70n le=900n Nx=2 m=1
Q$35 LB \$277 \$268 GND npn13G2 we=70n le=900n Nx=2 m=1
Q$36 PLLN \$381 \$396 GND npn13G2 we=70n le=900n Nx=4 m=1
Q$37 PLLP \$433 \$396 GND npn13G2 we=70n le=900n Nx=4 m=1
Q$38 LC|VCC LA$2 \$331 GND npn13G2 we=70n le=900n Nx=2 m=1
Q$39 LC|VCC LB$2 \$332 GND npn13G2 we=70n le=900n Nx=2 m=1
Q$40 LA$1 \$458 \$430 GND npn13G2 we=70n le=900n Nx=2 m=1
Q$41 LB$1 \$464 \$430 GND npn13G2 we=70n le=900n Nx=2 m=1
Q$42 LA$2 \$527 \$534 GND npn13G2 we=70n le=900n Nx=4 m=1
Q$43 LB$2 \$528 \$534 GND npn13G2 we=70n le=900n Nx=4 m=1
R$44 \$6 LC|VCC GND rppd w=1u l=15.21u ps=0u b=0 m=1
R$45 GND \$6 GND rppd w=1u l=22.95u ps=0u b=0 m=1
R$46 \$8 \$6 GND rppd w=1u l=7.47u ps=0u b=0 m=1
R$47 \$4 \$6 GND rppd w=1u l=7.47u ps=0u b=0 m=1
R$48 GND \$10 GND rppd w=4u l=2.05u ps=0u b=0 m=1
R$49 GND \$11 GND rppd w=4u l=1.28u ps=0u b=0 m=1
R$50 GND \$12 GND rppd w=2u l=2.05u ps=0u b=0 m=1
R$51 \$46 LC|VCC GND rppd w=2u l=2.83u ps=0u b=0 m=1
R$52 \$47 LC|VCC GND rppd w=2u l=2.83u ps=0u b=0 m=1
R$53 \$49 LC|VCC GND rppd w=2u l=1.79u ps=0u b=0 m=1
R$54 \$50 LC|VCC GND rppd w=2u l=1.79u ps=0u b=0 m=1
R$55 \$132 LC|VCC GND rppd w=1u l=11.34u ps=0u b=0 m=1
R$56 GND \$135 GND rppd w=4u l=2.05u ps=0u b=0 m=1
R$57 GND \$143 GND rppd w=4u l=1.28u ps=0u b=0 m=1
R$58 \$44 LC|VCC GND rppd w=2u l=2.83u ps=0u b=0 m=1
R$59 \$41 LC|VCC GND rppd w=2u l=2.83u ps=0u b=0 m=1
R$60 \$258 LC|VCC GND rppd w=2u l=1.79u ps=0u b=0 m=1
R$61 \$42 LC|VCC GND rppd w=2u l=1.79u ps=0u b=0 m=1
R$62 \$7 \$6 GND rppd w=1u l=19.08u ps=0u b=0 m=1
R$63 \$3 \$6 GND rppd w=1u l=19.08u ps=0u b=0 m=1
R$64 LC|VCC \$242 GND rppd w=1u l=17.53u ps=0u b=0 m=1
R$65 GND \$242 GND rppd w=1u l=20.63u ps=0u b=0 m=1
R$66 \$242 \$274 GND rppd w=1u l=19.08u ps=0u b=0 m=1
R$67 GND \$268 GND rppd w=2u l=0.94u ps=0u b=0 m=1
R$68 \$242 \$277 GND rppd w=1u l=19.08u ps=0u b=0 m=1
R$69 LC|VCC LA GND rppd w=2u l=2.83u ps=0u b=0 m=1
R$70 LC|VCC LB GND rppd w=2u l=2.83u ps=0u b=0 m=1
R$71 LC|VCC \$299 GND rppd w=1u l=17.53u ps=0u b=0 m=1
R$72 GND \$299 GND rppd w=1u l=20.63u ps=0u b=0 m=1
R$73 \$299 \$348 GND rppd w=1u l=19.08u ps=0u b=0 m=1
R$74 \$299 \$349 GND rppd w=1u l=19.08u ps=0u b=0 m=1
R$75 GND \$339 GND rppd w=2u l=1.86u ps=0u b=0 m=1
R$76 LC|VCC \$306 GND rppd w=2u l=2.05u ps=0u b=0 m=1
R$77 LC|VCC \$307 GND rppd w=2u l=2.05u ps=0u b=0 m=1
R$78 GND \$331 GND rppd w=2u l=8.24u ps=0u b=0 m=1
R$79 GND \$332 GND rppd w=2u l=8.24u ps=0u b=0 m=1
R$80 LC|VCC \$368 GND rppd w=1u l=17.53u ps=0u b=0 m=1
R$81 GND \$368 GND rppd w=1u l=20.63u ps=0u b=0 m=1
R$82 GND \$402 GND rppd w=8u l=0.66u ps=0u b=0 m=1
R$83 GND \$403 GND rppd w=8u l=0.66u ps=0u b=0 m=1
R$84 \$368 \$458 GND rppd w=1u l=19.08u ps=0u b=0 m=1
R$85 \$368 \$464 GND rppd w=1u l=19.08u ps=0u b=0 m=1
R$86 GND \$430 GND rppd w=2u l=1.86u ps=0u b=0 m=1
R$87 PLLN LC|VCC GND rppd w=10u l=1.66u ps=0u b=0 m=1
R$88 PLLP LC|VCC GND rppd w=10u l=1.66u ps=0u b=0 m=1
R$89 LC|VCC LA$1 GND rppd w=2u l=2.83u ps=0u b=0 m=1
R$90 LC|VCC LB$1 GND rppd w=2u l=2.83u ps=0u b=0 m=1
R$91 LC|VCC \$502 GND rppd w=1u l=15.21u ps=0u b=0 m=1
R$92 GND \$502 GND rppd w=1u l=22.95u ps=0u b=0 m=1
R$93 \$505 LC|VCC GND rppd w=1u l=17.14u ps=0u b=0 m=1
R$94 \$381 \$505 GND rppd w=1u l=19.08u ps=0u b=0 m=1
R$95 \$433 \$505 GND rppd w=1u l=19.08u ps=0u b=0 m=1
R$96 GND \$534 GND rppd w=2u l=1.41u ps=0u b=0 m=1
R$97 \$502 \$527 GND rppd w=1u l=7.47u ps=0u b=0 m=1
R$98 \$502 \$528 GND rppd w=1u l=7.47u ps=0u b=0 m=1
R$99 GND RXLOP GND rhigh w=1u l=14u ps=0u b=0 m=1
R$100 GND RXLON GND rhigh w=1u l=14u ps=0u b=0 m=1
R$101 GND TXLOP GND rhigh w=1u l=14u ps=0u b=0 m=1
R$102 GND TXLON GND rhigh w=1u l=14u ps=0u b=0 m=1
R$103 \$501 G1 GND rhigh w=1u l=7u ps=0u b=0 m=1
R$104 \$501 G2 GND rhigh w=1u l=7u ps=0u b=0 m=1
R$105 \$501 LC|VCC GND rhigh w=1u l=13.3u ps=0u b=0 m=1
R$106 \$501 GND GND rhigh w=1u l=13.3u ps=0u b=0 m=1
R$107 GND \$505 GND rhigh w=1u l=5.53u ps=0u b=0 m=1
C$108 \$6 GND GND rfcmim w=33u l=33u A=1089p P=132u m=1 wfeed=3u
C$109 \$132 GND GND rfcmim w=25u l=25u A=625p P=100u m=1 wfeed=3u
C$110 \$242 GND GND rfcmim w=33u l=33u A=1089p P=132u m=1 wfeed=3u
C$111 LA RXLOP GND rfcmim w=12u l=12u A=144p P=48u m=1 wfeed=3u
C$112 LB RXLON GND rfcmim w=12u l=12u A=144p P=48u m=1 wfeed=3u
C$113 \$42 \$7 GND rfcmim w=18.2u l=18.2u A=331.24p P=72.8u m=1 wfeed=3u
C$114 \$299 GND GND rfcmim w=33u l=33u A=1089p P=132u m=1 wfeed=3u
C$115 \$258 \$3 GND rfcmim w=18.2u l=18.2u A=331.24p P=72.8u m=1 wfeed=3u
C$116 \$306 \$8 GND rfcmim w=12u l=12u A=144p P=48u m=1 wfeed=3u
C$117 \$307 \$4 GND rfcmim w=12u l=12u A=144p P=48u m=1 wfeed=3u
C$118 \$331 \$274 GND rfcmim w=25u l=25u A=625p P=100u m=1 wfeed=3u
C$119 \$332 \$277 GND rfcmim w=25u l=25u A=625p P=100u m=1 wfeed=3u
C$120 \$368 GND GND rfcmim w=33u l=33u A=1089p P=132u m=1 wfeed=3u
C$121 LA$1 TXLOP GND rfcmim w=12u l=12u A=144p P=48u m=1 wfeed=3u
C$122 LB$1 TXLON GND rfcmim w=12u l=12u A=144p P=48u m=1 wfeed=3u
C$123 \$41 \$381 GND rfcmim w=18.2u l=18.2u A=331.24p P=72.8u m=1 wfeed=3u
C$124 \$331 \$348 GND rfcmim w=25u l=25u A=625p P=100u m=1 wfeed=3u
C$125 \$332 \$349 GND rfcmim w=25u l=25u A=625p P=100u m=1 wfeed=3u
C$126 \$44 \$433 GND rfcmim w=18.2u l=18.2u A=331.24p P=72.8u m=1 wfeed=3u
C$127 \$501 GND GND rfcmim w=33u l=33u A=1089p P=132u m=1 wfeed=3u
C$128 LA$2 G1 GND rfcmim w=8.55u l=8.55u A=73.1025p P=34.2u m=1 wfeed=3u
C$129 LB$2 G2 GND rfcmim w=8.55u l=8.55u A=73.1025p P=34.2u m=1 wfeed=3u
C$130 \$502 GND GND rfcmim w=33u l=33u A=1089p P=132u m=1 wfeed=3u
C$131 \$505 GND GND rfcmim w=33u l=33u A=1089p P=132u m=1 wfeed=3u
C$132 LB$2 \$527 GND rfcmim w=11.5u l=11.5u A=132.25p P=46u m=1 wfeed=3u
C$133 LA$2 \$528 GND rfcmim w=11.5u l=11.5u A=132.25p P=46u m=1 wfeed=3u
C$134 \$331 \$458 GND rfcmim w=25u l=25u A=625p P=100u m=1 wfeed=3u
C$135 \$332 \$464 GND rfcmim w=25u l=25u A=625p P=100u m=1 wfeed=3u
C$136 G1 VTUNE|W G2 GND sg13_hv_svaricap w=9.74u l=0.3u Nx=10
L$137 LB LC|VCC LA GND inductor3 w=4u s=2.097u d=65.386u nr_r=2
L$138 LA$2 LC|VCC LB$2 GND inductor3 w=6u s=2.097u d=70.906u nr_r=2
L$139 LA$1 LC|VCC LB$1 GND inductor3 w=4u s=2.097u d=83.496u nr_r=2
.ENDS lo_core
