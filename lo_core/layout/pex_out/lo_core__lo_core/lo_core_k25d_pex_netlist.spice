*********************************************************
*** NGSPICE file created by KLayout-PEX 0.4.4
*** -----------------------------------------------------
***     Extraction Engine: KPEX/2.5D
***     Technology: ihp_sg13g2
***     Date: 2026-10-16 04:40:46
*********************************************************

.SUBCKT lo_core BSEL GND PLLN PLLP RXLON RXLOP TXLON TXLOP VCC VTUNE
