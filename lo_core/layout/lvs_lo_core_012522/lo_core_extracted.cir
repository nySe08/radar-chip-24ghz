* Extracted by KLayout with SG13G2 LVS runset on : 14/10/2026 01:25

.SUBCKT lo_core BSEL G1 G2 GND LA LA$1 LA$2 LB LB$1 LB$2 LC|VCC PLLN PLLP RXLON
+ RXLOP TXLON TXLOP VTUNE|W
M$1 \$383 \$406 \$384 GND sg13_lv_nmos L=0.13u W=24u AS=4.86p AD=4.86p
+ PS=30.86u PD=30.86u rfmode=0
Q$13 \$17 \$132 \$11 GND npn13G2 we=70n le=900n Nx=6 m=1
Q$14 \$18 \$132 \$22 GND npn13G2 we=70n le=900n Nx=9 m=1
Q$15 \$46 \$464 \$45 GND npn13G2 we=70n le=900n Nx=1 m=1
Q$16 \$47 \$41 \$45 GND npn13G2 we=70n le=900n Nx=1 m=1
Q$17 \$47 \$46 \$75 GND npn13G2 we=70n le=900n Nx=1 m=1
Q$18 \$75 \$3 \$17 GND npn13G2 we=70n le=900n Nx=1 m=1
Q$19 \$48 \$8 \$18 GND npn13G2 we=70n le=900n Nx=1 m=1
Q$20 \$49 \$44 \$48 GND npn13G2 we=70n le=900n Nx=1 m=1
Q$21 \$49 \$50 \$76 GND npn13G2 we=70n le=900n Nx=1 m=1
Q$22 \$132 \$132 \$12 GND npn13G2 we=70n le=900n Nx=1 m=1
Q$23 \$45 \$7 \$17 GND npn13G2 we=70n le=900n Nx=1 m=1
Q$24 \$46 \$47 \$75 GND npn13G2 we=70n le=900n Nx=1 m=1
Q$25 \$50 \$42 \$48 GND npn13G2 we=70n le=900n Nx=1 m=1
Q$26 \$50 \$49 \$76 GND npn13G2 we=70n le=900n Nx=1 m=1
Q$27 \$76 \$4 \$18 GND npn13G2 we=70n le=900n Nx=1 m=1
Q$28 \$464 \$47 \$157 GND npn13G2 we=70n le=900n Nx=1 m=1
Q$29 \$41 \$46 \$157 GND npn13G2 we=70n le=900n Nx=1 m=1
Q$30 \$137 \$132 \$136 GND npn13G2 we=70n le=900n Nx=6 m=1
Q$31 \$464 \$41 \$184 GND npn13G2 we=70n le=900n Nx=1 m=1
Q$32 \$41 \$464 \$184 GND npn13G2 we=70n le=900n Nx=1 m=1
Q$33 \$184 \$7 \$137 GND npn13G2 we=70n le=900n Nx=1 m=1
Q$34 \$138 \$132 \$133 GND npn13G2 we=70n le=900n Nx=9 m=1
Q$35 \$44 \$42 \$185 GND npn13G2 we=70n le=900n Nx=1 m=1
Q$36 \$42 \$44 \$185 GND npn13G2 we=70n le=900n Nx=1 m=1
Q$37 \$185 \$8 \$138 GND npn13G2 we=70n le=900n Nx=1 m=1
Q$38 \$157 \$3 \$137 GND npn13G2 we=70n le=900n Nx=1 m=1
Q$39 \$158 \$4 \$138 GND npn13G2 we=70n le=900n Nx=1 m=1
Q$40 \$44 \$50 \$158 GND npn13G2 we=70n le=900n Nx=1 m=1
Q$41 \$42 \$49 \$158 GND npn13G2 we=70n le=900n Nx=1 m=1
Q$42 \$418 \$132 \$398 GND npn13G2 we=70n le=900n Nx=10 m=1
Q$43 \$418 \$132 \$399 GND npn13G2 we=70n le=900n Nx=10 m=1
Q$44 \$305 \$348 \$341 GND npn13G2 we=70n le=900n Nx=2 m=1
Q$45 \$306 \$349 \$341 GND npn13G2 we=70n le=900n Nx=2 m=1
Q$46 LA \$272 \$278 GND npn13G2 we=70n le=900n Nx=2 m=1
Q$47 LB \$275 \$278 GND npn13G2 we=70n le=900n Nx=2 m=1
Q$48 PLLN \$451 \$418 GND npn13G2 we=70n le=900n Nx=4 m=1
Q$49 PLLP \$452 \$418 GND npn13G2 we=70n le=900n Nx=4 m=1
Q$50 LC|VCC LA$2 \$332 GND npn13G2 we=70n le=900n Nx=2 m=1
Q$51 LC|VCC LB$2 \$323 GND npn13G2 we=70n le=900n Nx=2 m=1
Q$52 LA$1 \$477 \$446 GND npn13G2 we=70n le=900n Nx=2 m=1
Q$53 LB$1 \$482 \$446 GND npn13G2 we=70n le=900n Nx=2 m=1
Q$54 LA$2 \$547 \$558 GND npn13G2 we=70n le=900n Nx=4 m=1
Q$55 LB$2 \$551 \$558 GND npn13G2 we=70n le=900n Nx=4 m=1
R$56 \$6 LC|VCC GND rppd w=1u l=15.21u ps=0u b=0 m=1
R$57 GND \$6 GND rppd w=1u l=22.95u ps=0u b=0 m=1
R$58 \$8 \$6 GND rppd w=1u l=7.47u ps=0u b=0 m=1
R$59 \$4 \$6 GND rppd w=1u l=7.47u ps=0u b=0 m=1
R$60 GND \$11 GND rppd w=8u l=1.28u ps=0u b=0 m=1
R$61 GND \$22 GND rppd w=8u l=0.75u ps=0u b=0 m=1
R$62 GND \$12 GND rppd w=2u l=2.05u ps=0u b=0 m=1
R$63 \$46 LC|VCC GND rppd w=2u l=0.76u ps=0u b=0 m=1
R$64 \$47 LC|VCC GND rppd w=2u l=0.76u ps=0u b=0 m=1
R$65 \$49 LC|VCC GND rppd w=4u l=1.11u ps=0u b=0 m=1
R$66 \$50 LC|VCC GND rppd w=4u l=1.11u ps=0u b=0 m=1
R$67 \$132 LC|VCC GND rppd w=1u l=11.34u ps=0u b=0 m=1
R$68 GND \$136 GND rppd w=8u l=1.28u ps=0u b=0 m=1
R$69 GND \$133 GND rppd w=8u l=0.75u ps=0u b=0 m=1
R$70 \$464 LC|VCC GND rppd w=2u l=0.76u ps=0u b=0 m=1
R$71 \$41 LC|VCC GND rppd w=2u l=0.76u ps=0u b=0 m=1
R$72 \$44 LC|VCC GND rppd w=4u l=1.11u ps=0u b=0 m=1
R$73 \$42 LC|VCC GND rppd w=4u l=1.11u ps=0u b=0 m=1
R$74 \$7 \$6 GND rppd w=1u l=19.08u ps=0u b=0 m=1
R$75 \$3 \$6 GND rppd w=1u l=19.08u ps=0u b=0 m=1
R$76 LC|VCC \$242 GND rppd w=1u l=17.53u ps=0u b=0 m=1
R$77 GND \$242 GND rppd w=1u l=20.63u ps=0u b=0 m=1
R$78 \$242 \$272 GND rppd w=1u l=19.08u ps=0u b=0 m=1
R$79 GND \$278 GND rppd w=2u l=0.53u ps=0u b=0 m=1
R$80 \$242 \$275 GND rppd w=1u l=19.08u ps=0u b=0 m=1
R$81 LC|VCC LA GND rppd w=2u l=2.83u ps=0u b=0 m=1
R$82 LC|VCC LB GND rppd w=2u l=2.83u ps=0u b=0 m=1
R$83 LC|VCC \$298 GND rppd w=1u l=17.53u ps=0u b=0 m=1
R$84 GND \$298 GND rppd w=1u l=20.63u ps=0u b=0 m=1
R$85 \$298 \$348 GND rppd w=1u l=19.08u ps=0u b=0 m=1
R$86 \$298 \$349 GND rppd w=1u l=19.08u ps=0u b=0 m=1
R$87 GND \$341 GND rppd w=4u l=1u ps=0u b=0 m=1
R$88 LC|VCC \$305 GND rppd w=2u l=0.89u ps=0u b=0 m=1
R$89 LC|VCC \$306 GND rppd w=2u l=0.89u ps=0u b=0 m=1
R$90 GND \$332 GND rppd w=2u l=5.15u ps=0u b=0 m=1
R$91 GND \$323 GND rppd w=2u l=5.15u ps=0u b=0 m=1
R$92 LC|VCC \$367 GND rppd w=1u l=17.53u ps=0u b=0 m=1
R$93 GND \$367 GND rppd w=1u l=20.63u ps=0u b=0 m=1
R$94 GND \$398 GND rppd w=16u l=0.97u ps=0u b=0 m=1
R$95 GND \$399 GND rppd w=16u l=0.97u ps=0u b=0 m=1
R$96 \$367 \$477 GND rppd w=1u l=19.08u ps=0u b=0 m=1
R$97 \$367 \$482 GND rppd w=1u l=19.08u ps=0u b=0 m=1
R$98 GND \$446 GND rppd w=2u l=1.15u ps=0u b=0 m=1
R$99 PLLN LC|VCC GND rppd w=10u l=1.66u ps=0u b=0 m=1
R$100 PLLP LC|VCC GND rppd w=10u l=1.66u ps=0u b=0 m=1
R$101 LC|VCC LA$1 GND rppd w=2u l=2.83u ps=0u b=0 m=1
R$102 LC|VCC LB$1 GND rppd w=2u l=2.83u ps=0u b=0 m=1
R$103 LC|VCC \$519 GND rppd w=1u l=15.21u ps=0u b=0 m=1
R$104 GND \$519 GND rppd w=1u l=22.95u ps=0u b=0 m=1
R$105 \$524 LC|VCC GND rppd w=1u l=17.14u ps=0u b=0 m=1
R$106 \$451 \$524 GND rppd w=1u l=19.08u ps=0u b=0 m=1
R$107 \$452 \$524 GND rppd w=1u l=19.08u ps=0u b=0 m=1
R$108 GND \$558 GND rppd w=2u l=1.03u ps=0u b=0 m=1
R$109 \$519 \$547 GND rppd w=1u l=7.47u ps=0u b=0 m=1
R$110 \$519 \$551 GND rppd w=1u l=7.47u ps=0u b=0 m=1
R$111 GND RXLOP GND rhigh w=1u l=14u ps=0u b=0 m=1
R$112 GND RXLON GND rhigh w=1u l=14u ps=0u b=0 m=1
R$113 GND TXLOP GND rhigh w=1u l=14u ps=0u b=0 m=1
R$114 GND TXLON GND rhigh w=1u l=14u ps=0u b=0 m=1
R$115 GND \$383 GND rhigh w=1u l=14u ps=0u b=0 m=1
R$116 GND \$384 GND rhigh w=1u l=14u ps=0u b=0 m=1
R$117 BSEL \$406 GND rhigh w=1u l=14u ps=0u b=0 m=1
R$118 \$518 G1 GND rhigh w=1u l=7u ps=0u b=0 m=1
R$119 \$518 G2 GND rhigh w=1u l=7u ps=0u b=0 m=1
R$120 \$518 LC|VCC GND rhigh w=1u l=13.3u ps=0u b=0 m=1
R$121 \$518 GND GND rhigh w=1u l=13.3u ps=0u b=0 m=1
R$122 GND \$524 GND rhigh w=1u l=5.53u ps=0u b=0 m=1
C$123 \$6 GND GND rfcmim w=33u l=33u A=1089p P=132u m=1 wfeed=3u
C$124 \$132 GND GND rfcmim w=25u l=25u A=625p P=100u m=1 wfeed=3u
C$125 \$242 GND GND rfcmim w=33u l=33u A=1089p P=132u m=1 wfeed=3u
C$126 LA RXLOP GND rfcmim w=12u l=12u A=144p P=48u m=1 wfeed=3u
C$127 LB RXLON GND rfcmim w=12u l=12u A=144p P=48u m=1 wfeed=3u
C$128 \$42 \$7 GND rfcmim w=8u l=8u A=64p P=32u m=1 wfeed=3u
C$129 \$298 GND GND rfcmim w=33u l=33u A=1089p P=132u m=1 wfeed=3u
C$130 \$44 \$3 GND rfcmim w=8u l=8u A=64p P=32u m=1 wfeed=3u
C$131 \$305 \$8 GND rfcmim w=12u l=12u A=144p P=48u m=1 wfeed=3u
C$132 \$306 \$4 GND rfcmim w=12u l=12u A=144p P=48u m=1 wfeed=3u
C$133 \$332 \$272 GND rfcmim w=12u l=12u A=144p P=48u m=1 wfeed=3u
C$134 \$323 \$275 GND rfcmim w=12u l=12u A=144p P=48u m=1 wfeed=3u
C$135 \$367 GND GND rfcmim w=33u l=33u A=1089p P=132u m=1 wfeed=3u
C$136 LA$1 TXLOP GND rfcmim w=12u l=12u A=144p P=48u m=1 wfeed=3u
C$137 LB$1 TXLON GND rfcmim w=12u l=12u A=144p P=48u m=1 wfeed=3u
C$138 \$41 \$451 GND rfcmim w=18.2u l=18.2u A=331.24p P=72.8u m=1 wfeed=3u
C$139 \$323 \$349 GND rfcmim w=12u l=12u A=144p P=48u m=1 wfeed=3u
C$140 LA$2 \$383 GND rfcmim w=4.5u l=4.5u A=20.25p P=18u m=1 wfeed=3u
C$141 LB$2 \$384 GND rfcmim w=4.5u l=4.5u A=20.25p P=18u m=1 wfeed=3u
C$142 \$464 \$452 GND rfcmim w=18.2u l=18.2u A=331.24p P=72.8u m=1 wfeed=3u
C$143 \$332 \$348 GND rfcmim w=12u l=12u A=144p P=48u m=1 wfeed=3u
C$144 LA$2 G1 GND rfcmim w=16u l=16u A=256p P=64u m=1 wfeed=3u
C$145 LB$2 G2 GND rfcmim w=16u l=16u A=256p P=64u m=1 wfeed=3u
C$146 \$524 GND GND rfcmim w=33u l=33u A=1089p P=132u m=1 wfeed=3u
C$147 \$518 GND GND rfcmim w=33u l=33u A=1089p P=132u m=1 wfeed=3u
C$148 \$519 GND GND rfcmim w=33u l=33u A=1089p P=132u m=1 wfeed=3u
C$149 LB$2 \$547 GND rfcmim w=9u l=9u A=81p P=36u m=1 wfeed=3u
C$150 LA$2 \$551 GND rfcmim w=9u l=9u A=81p P=36u m=1 wfeed=3u
C$151 \$332 \$477 GND rfcmim w=12u l=12u A=144p P=48u m=1 wfeed=3u
C$152 \$323 \$482 GND rfcmim w=12u l=12u A=144p P=48u m=1 wfeed=3u
C$153 G1 VTUNE|W G2 GND sg13_hv_svaricap w=9.74u l=0.3u Nx=7
L$154 LB LC|VCC LA GND inductor3 w=4u s=2.097u d=65.386u nr_r=2
L$155 LA$2 LC|VCC LB$2 GND inductor3 w=6u s=2.097u d=58.846u nr_r=2
L$156 LA$1 LC|VCC LB$1 GND inductor3 w=4u s=2.097u d=83.496u nr_r=2
.ENDS lo_core
