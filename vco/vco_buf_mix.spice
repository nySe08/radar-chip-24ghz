* ============================================================
* 24 GHz VCO + LO buffer + mixer  (IHP SG13G2)
*  LO buffer: emitter followers -> AC-coupled, re-biased bases ->
*  three differential drivers with tuned loads (LDx || RDx):
*    driver 1 -> mixer LO, driver 2 -> PA, driver 3 -> divider
*  The mixer is the real circuit; its LO comes from driver 1.
* Run via run_lo_chain.py (it uses a robust start: DC solved without
* the varactor, then the transient starts from that point with UIC).
* ============================================================
.lib cornerHBT.lib hbt_typ
.lib cornerMOShv.lib mos_tt
.param temp=27
.param LH=330p QL=15 W0=1.5158e11      $ half-inductor (diff L = 660 pH), Q, 2*pi*24.125G
.param NXQ=4 ITAIL=3m VBB=1.5 CCB=200f RBB=2k    $ core transistors, tail current, base bias
.param NXV=10 CCV=250f VGB=1.25 RGB=10k VTUNE=1.25  $ varactor size, coupling cap, gate bias, tuning V
.param CLOAD=10f VCC=2.5 SELFT=1
* tank: center-tapped inductor (two halves, each with loss)
L1 vcc t1 {LH}
R1 t1 outp {W0*LH/QL}
L2 vcc t2 {LH}
R2 t2 outn {W0*LH/QL}
* varactor, AC-coupled, gates biased at VGB, well = Vtune
Ccv1 outp g1 {CCV}
Ccv2 outn g2 {CCV}
Rg1 vgb g1 {RGB}
Rg2 vgb g2 {RGB}
Vgb vgb 0 {VGB}
XV1 g1 vt g2 0 sg13_hv_svaricap l=0.3u w=9.74u Nx={NXV}
Vt vt 0 {VTUNE}
* cross-coupled pair with AC-coupled bases
XQ6 outp b6 tail 0 npn13G2 Nx={NXQ} selft={SELFT}
XQ7 outn b7 tail 0 npn13G2 Nx={NXQ} selft={SELFT}
Cb6 outn b6 {CCB}
Cb7 outp b7 {CCB}
Rb6 vbb b6 {RBB}
Rb7 vbb b7 {RBB}
Vbb vbb 0 {VBB}
It tail 0 {ITAIL}

* ================= LO BUFFER =================
.param NXEF=2 IEF=1.5m
.param NXD=2 ID1=2m ID2=2m ID3=1.5m
.param LD1=1.3n RD1=400 LD2=1.1n RD2=400 LD3=1.5n RD3=400
.param CC=500f
* --- load models (replaced by the real blocks later)
.param CMIX=25f RMIX=2k CPA=40f RPA=1k CDIV=10f RDIV=2k
* stage 1: emitter followers (high input impedance, level shift)
XQe1 vcc outp ef1 0 npn13G2 Nx={NXEF} selft={SELFT}
XQe2 vcc outn ef2 0 npn13G2 Nx={NXEF} selft={SELFT}
Ie1 ef1 0 {IEF}
Ie2 ef2 0 {IEF}
* AC coupling + re-bias of the driver bases (keeps the drivers out of saturation)
.param CDB=1p RDB=2k VBD=1.35
Cdb1 ef1 b1 {CDB}
Cdb2 ef2 b2 {CDB}
Rdb1 vbd b1 {RDB}
Rdb2 vbd b2 {RDB}
Vbd vbd 0 {VBD}
* stage 2: three parallel differential drivers with tuned loads
* driver 1 -> mixer LO
XQ11 d1p b2 dt1 0 npn13G2 Nx={NXD} selft={SELFT}
XQ12 d1n b1 dt1 0 npn13G2 Nx={NXD} selft={SELFT}
It1 dt1 0 {ID1}
L11 vcc d1p {LD1}
L12 vcc d1n {LD1}
R11 vcc d1p {RD1}
R12 vcc d1n {RD1}
* driver 2 -> PA
XQ21 d2p b2 dt2 0 npn13G2 Nx={NXD} selft={SELFT}
XQ22 d2n b1 dt2 0 npn13G2 Nx={NXD} selft={SELFT}
It2 dt2 0 {ID2}
L21 vcc d2p {LD2}
L22 vcc d2n {LD2}
R21 vcc d2p {RD2}
R22 vcc d2n {RD2}
* driver 3 -> divider
XQ31 d3p b2 dt3 0 npn13G2 Nx={NXD} selft={SELFT}
XQ32 d3n b1 dt3 0 npn13G2 Nx={NXD} selft={SELFT}
It3 dt3 0 {ID3}
L31 vcc d3p {LD3}
L32 vcc d3n {LD3}
R31 vcc d3p {RD3}
R32 vcc d3n {RD3}
* AC-coupled load models
Cm1 d1p m1 {CC}
Cm2 d1n m2 {CC}
Rmx1 m1 vlo {RMIX}
Rmx2 m2 vlo {RMIX}
Vlo vlo 0 1.9
Cp1 d2p p1 {CC}
Cp2 d2n p2 {CC}
Cpa1 p1 0 {CPA}
Cpa2 p2 0 {CPA}
Rpa1 p1 vpa {RPA}
Rpa2 p2 vpa {RPA}
Vpa vpa 0 1.0
Cd1 d3p q1 {CC}
Cd2 d3n q2 {CC}
Cdv1 q1 0 {CDIV}
Cdv2 q2 0 {CDIV}
Rdv1 q1 vdv {RDIV}
Rdv2 q2 vdv {RDIV}
Vdv vdv 0 1.9

* ================= MIXER (real circuit, LO from the buffer) =================
.param RE=75 RL=300 CL=1.76p RT=60 VB3=1.178 FRF=23.956e9 VRF=0.01
Vrf  src 0 dc 0 sin(0 {2*VRF} {FRF})
Rs   src rf 50
Cdc  rf b3 10p
Rt   vb3 b3 {RT}
Vb3  vb3 0 {VB3}
XQ3  x b3 e3 0 npn13G2 Nx=4
Re   e3 0 {RE}
XQ4  ifp m1 x 0 npn13G2 Nx=2
XQ5  ifn m2 x 0 npn13G2 Nx=2
RLp  vcc ifp {RL}
CLp  vcc ifp {CL}
RLn  vcc ifn {RL}
CLn  vcc ifn {CL}
* start-up kick
Ik outp 0 pulse(0 1m 0 5p 5p 10p 1)
Vcc vcc 0 {VCC}
.control
set noaskquit
tran 0.5p 6n
let vd = v(outp)-v(outn)
let vif = v(ifp)-v(ifn)
wrdata vco_tran.txt vd v(m1) v(m2) vif
.endc
.end
