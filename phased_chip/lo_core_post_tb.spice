* ============================================================
* 24 GHz FMCW radar - 2 TX / 4 RX PHASED-ARRAY CHIP, top level, REALIZED + all coils EM-fitted (VCO, pre-drivers, PA) (IHP SG13G2)
* VCO -> LO distribution -> 4 RX channels (LNA+mixer) and 2 switchable PAs, /4 divider.
* Test: TX1 on, TX2 off; a plane wave (echo) arrives at the 4 RX antennas from angle THETA:
*   element k sees phase  -180*k*sin(THETA) deg  (lambda/2 spacing)  -> must reappear at the 4 IFs.
* ============================================================
.lib cornerHBT.lib hbt_typ
.lib cornerMOShv.lib mos_tt
.lib cornerMOSlv.lib mos_tt
.lib cornerCAP.lib cap_typ
.lib cornerRES.lib res_typ
.param temp=27
.options reltol=1e-4
.include blocks/lna.sp
.include blocks/mixer.sp
.include blocks/vco_locore_post.sp
.include blocks/lodist_em.sp
.include blocks/tile_drivers.sp
.include blocks/mixer_real.sp

.include blocks/pa_em.sp
.param VCC=2.5 VTUNE=1.25 EN1B=0 EN2B=1.2
.param FECHO=24.0e9 PECHO=-40 THETA=20
.param VECHO={2*sqrt(100*1e-3*10**(PECHO/10))}
.param DPH={180*sin(THETA*3.14159265/180)}
Vcc vcc 0 {VCC}
Vtune vtune 0 {VTUNE}
Ven1 en1 0 {EN1B}
Ven2 en2 0 {EN2B}
* ---------------- chip ----------------
.param CCVT=280f RREFT=2.8u
* start-up kick (testbench only - on silicon the VCO starts from noise)
.param PAL=1u PACP=0 PARD=0.89u PART=0.79u PRL=300p PRT=0.94u
* ---- LO core (from its LVS netlist): VCO, emitter followers, RX/TX pre-drivers, divider driver, divider
* band select: BSEL = 0 -> upper sub-band, 1.2 V -> lower sub-band
.param BSEL=0
Vbsel bsel 0 {BSEL}
Xlo bsel 0 pll_p pll_n rxp rxn txp txn vcc vtune lo_core
* loads outside the LO core: 4 tile channel drivers (-> mixers) on the RX LO, 2 PA drivers on the TX LO
Xd1 rxp rxn l1p l1n vcc lodrv_res
Xd2 rxp rxn l2p l2n vcc lodrv_res
Xd3 rxp rxn l3p l3n vcc lodrv_res
Xd4 rxp rxn l4p l4n vcc lodrv_res
Xpd1 txp txn t1p t1n vcc lodrv_g L={PAL} CPAR={PACP} RDL={PARD} RTL={PART}
Xpd2 txp txn t2p t2n vcc lodrv_g L={PAL} CPAR={PACP} RDL={PARD} RTL={PART}
Xpa1 t1p tx1 en1 vcc pa_em RREFL={RREFT}
Xpa2 t2p tx2 en2 vcc pa_em RREFL={RREFT}
Cdm1 t1n dm1 1p
Rdm1 dm1 0 1k
Cdm2 t2n dm2 1p
Rdm2 dm2 0 1k
Rbl1 t1p 0 20k
Rbl2 t2p 0 20k
Rbl3 t1n 0 20k
Rbl4 t2n 0 20k

* 4 receive channels
Xlna1 rx1 a1 vcc lna
Xlna2 rx2 a2 vcc lna
Xlna3 rx3 a3 vcc lna
Xlna4 rx4 a4 vcc lna
Rba1 a1 0 20k
Rba2 a2 0 20k
Rba3 a3 0 20k
Rba4 a4 0 20k
Xmx1 a1 l1p l1n i1p i1n vcc mixer_real
Xmx2 a2 l2p l2n i2p i2n vcc mixer_real
Xmx3 a3 l3p l3n i3p i3n vcc mixer_real
Xmx4 a4 l4p l4n i4p i4n vcc mixer_real
* ---------------- outside world ----------------
Rtx1 tx1 0 50
Rtx2 tx2 0 50
Cx1 pll_p pllp 10p
Cx2 pll_n plln 10p
Rx1 pllp 0 50
Rx2 plln 0 50
* plane wave from angle THETA at the 4 RX antennas (50-ohm sources)
Ve1 s1 0 dc 0 sin(0 {VECHO} {FECHO} 0 0 0)
Ve2 s2 0 dc 0 sin(0 {VECHO} {FECHO} 0 0 {-1*DPH})
Ve3 s3 0 dc 0 sin(0 {VECHO} {FECHO} 0 0 {-2*DPH})
Ve4 s4 0 dc 0 sin(0 {VECHO} {FECHO} 0 0 {-3*DPH})
Rs1 s1 rx1 50
Rs2 s2 rx2 50
Rs3 s3 rx3 50
Rs4 s4 rx4 50
.control
set noaskquit
tran 0.5p 30n 0 0.5p
let vd = v(xlo.vcop)-v(xlo.vcon)
let if1 = v(i1p)-v(i1n)
let if2 = v(i2p)-v(i2n)
let if3 = v(i3p)-v(i3n)
let if4 = v(i4p)-v(i4n)
let lo1 = v(l1p)-v(l1n)
let lo4 = v(l4p)-v(l4n)
wrdata phased_tran.txt vd if1 if2 if3 if4 v(tx1) v(tx2) v(pllp) lo1 lo4
.endc
.end
